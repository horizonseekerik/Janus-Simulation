* SPICE SUB-CIRCUIT FOR OPTICAL_SWITCH_4PORT
.SUBCKT OPTICAL_SWITCH_4PORT P1_IN P1_OUT P2_IN P2_OUT P3_IN P3_OUT P4_IN P4_OUT GND
* Port Terminations (50 Ohms)
R_PORT1 P1_IN P1_OUT 50.0
R_PORT2 P2_IN P2_OUT 50.0
R_PORT3 P3_IN P3_OUT 50.0
R_PORT4 P4_IN P4_OUT 50.0
G_D_0_0 P1_IN GND P1_IN GND 9.0000e-01
G_D_1_1 P2_IN GND P2_IN GND 9.0000e-01
G_D_2_2 P3_IN GND P3_IN GND 9.0000e-01
G_D_3_3 P4_IN GND P4_IN GND 9.0000e-01
* Biquad Pair 1 State Nodes: alpha=3.14e+11, omega=1.88e+11
G_DRIVE_0_1_0 GND STATE_0_1_PORT_0 P1_IN GND 1.0000e+00
R_STATE_0_1_0 STATE_0_1_PORT_0 GND 3.1831e-12
C_STATE_0_1_0 STATE_0_1_PORT_0 GND 1.0000e+00
G_COUPLE_0_1_0 STATE_0_1_PORT_0 GND STATE_0_2_PORT_0 GND 1.8850e+11
R_STATE_0_2_0 STATE_0_2_PORT_0 GND 3.1831e-12
C_STATE_0_2_0 STATE_0_2_PORT_0 GND 1.0000e+00
G_COUPLE_0_2_0 GND STATE_0_2_PORT_0 STATE_0_1_PORT_0 GND 1.8850e+11
G_RES_RE_0_0_G0 P1_IN GND STATE_0_1_PORT_0 GND -3.6621e-04
G_RES_IM_0_0_G0 P1_IN GND STATE_0_2_PORT_0 GND -6.1035e-04
G_DRIVE_0_1_1 GND STATE_0_1_PORT_1 P2_IN GND 1.0000e+00
R_STATE_0_1_1 STATE_0_1_PORT_1 GND 3.1831e-12
C_STATE_0_1_1 STATE_0_1_PORT_1 GND 1.0000e+00
G_COUPLE_0_1_1 STATE_0_1_PORT_1 GND STATE_0_2_PORT_1 GND 1.8850e+11
R_STATE_0_2_1 STATE_0_2_PORT_1 GND 3.1831e-12
C_STATE_0_2_1 STATE_0_2_PORT_1 GND 1.0000e+00
G_COUPLE_0_2_1 GND STATE_0_2_PORT_1 STATE_0_1_PORT_1 GND 1.8850e+11
G_RES_RE_1_1_G0 P2_IN GND STATE_0_1_PORT_1 GND -3.6621e-04
G_RES_IM_1_1_G0 P2_IN GND STATE_0_2_PORT_1 GND -6.1035e-04
G_DRIVE_0_1_2 GND STATE_0_1_PORT_2 P3_IN GND 1.0000e+00
R_STATE_0_1_2 STATE_0_1_PORT_2 GND 3.1831e-12
C_STATE_0_1_2 STATE_0_1_PORT_2 GND 1.0000e+00
G_COUPLE_0_1_2 STATE_0_1_PORT_2 GND STATE_0_2_PORT_2 GND 1.8850e+11
R_STATE_0_2_2 STATE_0_2_PORT_2 GND 3.1831e-12
C_STATE_0_2_2 STATE_0_2_PORT_2 GND 1.0000e+00
G_COUPLE_0_2_2 GND STATE_0_2_PORT_2 STATE_0_1_PORT_2 GND 1.8850e+11
G_RES_RE_2_2_G0 P3_IN GND STATE_0_1_PORT_2 GND -3.6621e-04
G_RES_IM_2_2_G0 P3_IN GND STATE_0_2_PORT_2 GND -6.1035e-04
G_DRIVE_0_1_3 GND STATE_0_1_PORT_3 P4_IN GND 1.0000e+00
R_STATE_0_1_3 STATE_0_1_PORT_3 GND 3.1831e-12
C_STATE_0_1_3 STATE_0_1_PORT_3 GND 1.0000e+00
G_COUPLE_0_1_3 STATE_0_1_PORT_3 GND STATE_0_2_PORT_3 GND 1.8850e+11
R_STATE_0_2_3 STATE_0_2_PORT_3 GND 3.1831e-12
C_STATE_0_2_3 STATE_0_2_PORT_3 GND 1.0000e+00
G_COUPLE_0_2_3 GND STATE_0_2_PORT_3 STATE_0_1_PORT_3 GND 1.8850e+11
G_RES_RE_3_3_G0 P4_IN GND STATE_0_1_PORT_3 GND -3.6621e-04
G_RES_IM_3_3_G0 P4_IN GND STATE_0_2_PORT_3 GND -6.1035e-04
* Biquad Pair 2 State Nodes: alpha=6.28e+11, omega=3.77e+11
G_DRIVE_1_1_0 GND STATE_1_1_PORT_0 P1_IN GND 1.0000e+00
R_STATE_1_1_0 STATE_1_1_PORT_0 GND 1.5915e-12
C_STATE_1_1_0 STATE_1_1_PORT_0 GND 1.0000e+00
G_COUPLE_1_1_0 STATE_1_1_PORT_0 GND STATE_1_2_PORT_0 GND 3.7699e+11
R_STATE_1_2_0 STATE_1_2_PORT_0 GND 1.5915e-12
C_STATE_1_2_0 STATE_1_2_PORT_0 GND 1.0000e+00
G_COUPLE_1_2_0 GND STATE_1_2_PORT_0 STATE_1_1_PORT_0 GND 3.7699e+11
G_RES_RE_0_0_G1 P1_IN GND STATE_1_1_PORT_0 GND -2.9297e-03
G_RES_IM_0_0_G1 P1_IN GND STATE_1_2_PORT_0 GND 2.9297e-03
G_DRIVE_1_1_1 GND STATE_1_1_PORT_1 P2_IN GND 1.0000e+00
R_STATE_1_1_1 STATE_1_1_PORT_1 GND 1.5915e-12
C_STATE_1_1_1 STATE_1_1_PORT_1 GND 1.0000e+00
G_COUPLE_1_1_1 STATE_1_1_PORT_1 GND STATE_1_2_PORT_1 GND 3.7699e+11
R_STATE_1_2_1 STATE_1_2_PORT_1 GND 1.5915e-12
C_STATE_1_2_1 STATE_1_2_PORT_1 GND 1.0000e+00
G_COUPLE_1_2_1 GND STATE_1_2_PORT_1 STATE_1_1_PORT_1 GND 3.7699e+11
G_RES_RE_1_1_G1 P2_IN GND STATE_1_1_PORT_1 GND -2.9297e-03
G_RES_IM_1_1_G1 P2_IN GND STATE_1_2_PORT_1 GND 2.9297e-03
G_DRIVE_1_1_2 GND STATE_1_1_PORT_2 P3_IN GND 1.0000e+00
R_STATE_1_1_2 STATE_1_1_PORT_2 GND 1.5915e-12
C_STATE_1_1_2 STATE_1_1_PORT_2 GND 1.0000e+00
G_COUPLE_1_1_2 STATE_1_1_PORT_2 GND STATE_1_2_PORT_2 GND 3.7699e+11
R_STATE_1_2_2 STATE_1_2_PORT_2 GND 1.5915e-12
C_STATE_1_2_2 STATE_1_2_PORT_2 GND 1.0000e+00
G_COUPLE_1_2_2 GND STATE_1_2_PORT_2 STATE_1_1_PORT_2 GND 3.7699e+11
G_RES_RE_2_2_G1 P3_IN GND STATE_1_1_PORT_2 GND -2.9297e-03
G_RES_IM_2_2_G1 P3_IN GND STATE_1_2_PORT_2 GND 2.9297e-03
G_DRIVE_1_1_3 GND STATE_1_1_PORT_3 P4_IN GND 1.0000e+00
R_STATE_1_1_3 STATE_1_1_PORT_3 GND 1.5915e-12
C_STATE_1_1_3 STATE_1_1_PORT_3 GND 1.0000e+00
G_COUPLE_1_1_3 STATE_1_1_PORT_3 GND STATE_1_2_PORT_3 GND 3.7699e+11
R_STATE_1_2_3 STATE_1_2_PORT_3 GND 1.5915e-12
C_STATE_1_2_3 STATE_1_2_PORT_3 GND 1.0000e+00
G_COUPLE_1_2_3 GND STATE_1_2_PORT_3 STATE_1_1_PORT_3 GND 3.7699e+11
G_RES_RE_3_3_G1 P4_IN GND STATE_1_1_PORT_3 GND -2.9297e-03
G_RES_IM_3_3_G1 P4_IN GND STATE_1_2_PORT_3 GND 2.9297e-03
.ENDS OPTICAL_SWITCH_4PORT
